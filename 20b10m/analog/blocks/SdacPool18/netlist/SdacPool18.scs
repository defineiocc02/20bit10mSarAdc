// ============================================================
// [CODE-INDEX] SdacPool18.scs —— 18 片 DAC1 池（部分交织）
// 每片：3.456 pF = 128 × 27 fF，片内 7 bit；高 3 bit 由片间 unary 选择。
// 角色：ACQ<i>=1 时采样，CONV<i>=1 时转换；每 100 ns 交换一次。
// 顶板：VTOPP<i>/VTOPN<i> 独立引出，由 SliceMux 选 8 片汇到 RA。
// 假设：EN<i>=0 的备用片底板接 VCM；D<6:0> 为当前转换码。
// ============================================================
// SdacPool18.scs —— 18 片池（部分交织：8 转换 + 8 采样 + 2 备，角色每 100 ns 交换）
// 端口：VINP VINN VREFP VREFN VCM VGND D<6:0> ACQ<17:0> CONV<17:0> EN<17:0> VTOPP<17:0> VTOPN<17:0> VDD5 GND
// 说明：每片顶板独立引出到 VTOPP<i>/VTOPN<i>，由 SliceMux 选 8 片汇到 RA 输入。
simulator lang=spectre

subckt SdacPool18 VINP VINN VREFP VREFN VCM VGND D<6:0> ACQ<17:0> CONV<17:0> EN<17:0> VTOPP<17:0> VTOPN<17:0> VDD5 GND
// slice 0
Xs0 (VINP VINN VREFP VREFN VCM VGND D<6:0> ACQ<0> CONV<0> EN<0> VTOPP<0> VTOPN<0> VDD5 GND) SdacSlice
// slice 1
Xs1 (VINP VINN VREFP VREFN VCM VGND D<6:0> ACQ<1> CONV<1> EN<1> VTOPP<1> VTOPN<1> VDD5 GND) SdacSlice
// slice 2
Xs2 (VINP VINN VREFP VREFN VCM VGND D<6:0> ACQ<2> CONV<2> EN<2> VTOPP<2> VTOPN<2> VDD5 GND) SdacSlice
// slice 3
Xs3 (VINP VINN VREFP VREFN VCM VGND D<6:0> ACQ<3> CONV<3> EN<3> VTOPP<3> VTOPN<3> VDD5 GND) SdacSlice
// slice 4
Xs4 (VINP VINN VREFP VREFN VCM VGND D<6:0> ACQ<4> CONV<4> EN<4> VTOPP<4> VTOPN<4> VDD5 GND) SdacSlice
// slice 5
Xs5 (VINP VINN VREFP VREFN VCM VGND D<6:0> ACQ<5> CONV<5> EN<5> VTOPP<5> VTOPN<5> VDD5 GND) SdacSlice
// slice 6
Xs6 (VINP VINN VREFP VREFN VCM VGND D<6:0> ACQ<6> CONV<6> EN<6> VTOPP<6> VTOPN<6> VDD5 GND) SdacSlice
// slice 7
Xs7 (VINP VINN VREFP VREFN VCM VGND D<6:0> ACQ<7> CONV<7> EN<7> VTOPP<7> VTOPN<7> VDD5 GND) SdacSlice
// slice 8
Xs8 (VINP VINN VREFP VREFN VCM VGND D<6:0> ACQ<8> CONV<8> EN<8> VTOPP<8> VTOPN<8> VDD5 GND) SdacSlice
// slice 9
Xs9 (VINP VINN VREFP VREFN VCM VGND D<6:0> ACQ<9> CONV<9> EN<9> VTOPP<9> VTOPN<9> VDD5 GND) SdacSlice
// slice 10
Xs10 (VINP VINN VREFP VREFN VCM VGND D<6:0> ACQ<10> CONV<10> EN<10> VTOPP<10> VTOPN<10> VDD5 GND) SdacSlice
// slice 11
Xs11 (VINP VINN VREFP VREFN VCM VGND D<6:0> ACQ<11> CONV<11> EN<11> VTOPP<11> VTOPN<11> VDD5 GND) SdacSlice
// slice 12
Xs12 (VINP VINN VREFP VREFN VCM VGND D<6:0> ACQ<12> CONV<12> EN<12> VTOPP<12> VTOPN<12> VDD5 GND) SdacSlice
// slice 13
Xs13 (VINP VINN VREFP VREFN VCM VGND D<6:0> ACQ<13> CONV<13> EN<13> VTOPP<13> VTOPN<13> VDD5 GND) SdacSlice
// slice 14
Xs14 (VINP VINN VREFP VREFN VCM VGND D<6:0> ACQ<14> CONV<14> EN<14> VTOPP<14> VTOPN<14> VDD5 GND) SdacSlice
// slice 15
Xs15 (VINP VINN VREFP VREFN VCM VGND D<6:0> ACQ<15> CONV<15> EN<15> VTOPP<15> VTOPN<15> VDD5 GND) SdacSlice
// slice 16（备用）
Xs16 (VINP VINN VREFP VREFN VCM VGND D<6:0> ACQ<16> CONV<16> EN<16> VTOPP<16> VTOPN<16> VDD5 GND) SdacSlice
// slice 17（备用）
Xs17 (VINP VINN VREFP VREFN VCM VGND D<6:0> ACQ<17> CONV<17> EN<17> VTOPP<17> VTOPN<17> VDD5 GND) SdacSlice
ends SdacPool18
