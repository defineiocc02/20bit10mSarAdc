// ============================================================
// [CODE-INDEX] SdacPool18.scs —— 18 片 DAC1 池（部分交织）
// 每片：3.456 pF = 128 × 27 fF，片内 7 bit；高 3 bit 由片间 unary 选择（在数字 mapper 完成）。
// 角色：ACQ<i>=1 时采样，CONV<i>=1 时转换；每 100 ns 交换一次。
// 顶板：VTOPP<i>/VTOPN<i> 独立引出，由 SliceMux 选 8 片汇到 RA。
// 码：D<125:0> = 18 片 × 7 bit 物理掩码，bit[7i+6:7i] = 片 i；未选中片写 0（SSOT #28）。
// 假设：EN<i>=0 的备用片底板接 VCM；模拟不做 lane 散射，散射在数字侧完成。
// ============================================================
// 端口：VINP VINN VREFP VREFN VCM VGND D<125:0> ACQ<17:0> CONV<17:0> EN<17:0> VTOPP<17:0> VTOPN<17:0> VDD5 GND
simulator lang=spectre

subckt SdacPool18 VINP VINN VREFP VREFN VCM VGND D<125:0> ACQ<17:0> CONV<17:0> EN<17:0> VTOPP<17:0> VTOPN<17:0> VDD5 GND
Xs0  (VINP VINN VREFP VREFN VCM VGND D<6:0>     ACQ<0>  CONV<0>  EN<0>  VTOPP<0>  VTOPN<0>  VDD5 GND) SdacSlice
Xs1  (VINP VINN VREFP VREFN VCM VGND D<13:7>    ACQ<1>  CONV<1>  EN<1>  VTOPP<1>  VTOPN<1>  VDD5 GND) SdacSlice
Xs2  (VINP VINN VREFP VREFN VCM VGND D<20:14>   ACQ<2>  CONV<2>  EN<2>  VTOPP<2>  VTOPN<2>  VDD5 GND) SdacSlice
Xs3  (VINP VINN VREFP VREFN VCM VGND D<27:21>   ACQ<3>  CONV<3>  EN<3>  VTOPP<3>  VTOPN<3>  VDD5 GND) SdacSlice
Xs4  (VINP VINN VREFP VREFN VCM VGND D<34:28>   ACQ<4>  CONV<4>  EN<4>  VTOPP<4>  VTOPN<4>  VDD5 GND) SdacSlice
Xs5  (VINP VINN VREFP VREFN VCM VGND D<41:35>   ACQ<5>  CONV<5>  EN<5>  VTOPP<5>  VTOPN<5>  VDD5 GND) SdacSlice
Xs6  (VINP VINN VREFP VREFN VCM VGND D<48:42>   ACQ<6>  CONV<6>  EN<6>  VTOPP<6>  VTOPN<6>  VDD5 GND) SdacSlice
Xs7  (VINP VINN VREFP VREFN VCM VGND D<55:49>   ACQ<7>  CONV<7>  EN<7>  VTOPP<7>  VTOPN<7>  VDD5 GND) SdacSlice
Xs8  (VINP VINN VREFP VREFN VCM VGND D<62:56>   ACQ<8>  CONV<8>  EN<8>  VTOPP<8>  VTOPN<8>  VDD5 GND) SdacSlice
Xs9  (VINP VINN VREFP VREFN VCM VGND D<69:63>   ACQ<9>  CONV<9>  EN<9>  VTOPP<9>  VTOPN<9>  VDD5 GND) SdacSlice
Xs10 (VINP VINN VREFP VREFN VCM VGND D<76:70>   ACQ<10> CONV<10> EN<10> VTOPP<10> VTOPN<10> VDD5 GND) SdacSlice
Xs11 (VINP VINN VREFP VREFN VCM VGND D<83:77>   ACQ<11> CONV<11> EN<11> VTOPP<11> VTOPN<11> VDD5 GND) SdacSlice
Xs12 (VINP VINN VREFP VREFN VCM VGND D<90:84>   ACQ<12> CONV<12> EN<12> VTOPP<12> VTOPN<12> VDD5 GND) SdacSlice
Xs13 (VINP VINN VREFP VREFN VCM VGND D<97:91>   ACQ<13> CONV<13> EN<13> VTOPP<13> VTOPN<13> VDD5 GND) SdacSlice
Xs14 (VINP VINN VREFP VREFN VCM VGND D<104:98>  ACQ<14> CONV<14> EN<14> VTOPP<14> VTOPN<14> VDD5 GND) SdacSlice
Xs15 (VINP VINN VREFP VREFN VCM VGND D<111:105> ACQ<15> CONV<15> EN<15> VTOPP<15> VTOPN<15> VDD5 GND) SdacSlice
Xs16 (VINP VINN VREFP VREFN VCM VGND D<118:112> ACQ<16> CONV<16> EN<16> VTOPP<16> VTOPN<16> VDD5 GND) SdacSlice
Xs17 (VINP VINN VREFP VREFN VCM VGND D<125:119> ACQ<17> CONV<17> EN<17> VTOPP<17> VTOPN<17> VDD5 GND) SdacSlice
ends SdacPool18
