// Cmp2.scs —— 二级比较器（Pipe_SAR/comparator_pin 骨架，R1）
// 端口：VINP VINN CLK OUTP OUTN VDD18 GND
simulator lang=spectre

subckt Cmp2 VINP VINN CLK OUTP OUTN VDD18 GND
Mtail (tail CLK GND GND) nch18 w=12u l=0.18u
M1 (d1 VINP tail GND) nch18 w=16u l=0.18u
M2 (d2 VINN tail GND) nch18 w=16u l=0.18u
M3 (d1 d2 tail GND) nch18 w=6u l=0.18u
M4 (d2 d1 tail GND) nch18 w=6u l=0.18u
M5 (d1 CLK VDD18 VDD18) pch18 w=6u l=0.18u
M6 (d2 CLK VDD18 VDD18) pch18 w=6u l=0.18u
Xinv1 (d1 OUTN VDD18 GND) inv18
Xinv2 (d2 OUTP VDD18 GND) inv18
ends Cmp2
