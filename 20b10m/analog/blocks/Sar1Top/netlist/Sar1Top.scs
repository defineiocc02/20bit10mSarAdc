// Sar1Top.scs —— 一级（单套）：比较器 + 三电平驱动 + SAR1 逻辑（4b flash + 2b SAR + 5b 细搜）
// 端口：VTOPP VTOPN VREF VCM VGND COARSE<14:0> PHI_C0 PHI_C1 D1<10:0> SAMN<10:0> CMPP CMPN DONE1 VDD5 VDD18 GND
simulator lang=spectre

subckt Sar1Top VTOPP VTOPN VREF VCM VGND COARSE<14:0> PHI_C0 PHI_C1 D1<10:0> SAMN<10:0> CMPP CMPN DONE1 VDD5 VDD18 GND
Xcmp (VTOPP VTOPN PHI_C1 CMPP CMPN VDD18 GND) Cmp1
Xdrv (VREF VCM VGND D1<10:0> SAMN<10:0> SEG<10:0> VDD5 GND) TriLevelBank11
Xlogic (CMPP CMPN COARSE<14:0> PHI_C0 PHI_C1 D1<10:0> SAMN<10:0> DONE1 VDD18 GND) SarLogic1_stub
ends Sar1Top
